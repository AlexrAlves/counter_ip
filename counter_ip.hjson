{
    name: "counter_ip",
    clock_primary: "clk_i",
    reset_primary: "rst_ni",
    bus_device: "reg",
    bus_host: "",

    regwidth: "32",
    registers: [
        { name: "DTIN",
          desc: "Data to be loaded to the counter.",
          swaccess: "wo",
          hwaccess: "hro",
          hwext: "true",
          fields: [
            { bits: "15:0"
            }
          ],
        },
        { name: "CTOUT",
          desc: "Counter current value to be retrieved by software.",
          swaccess: "ro",
          hwaccess: "hwo",
          hwext: "true",
          fields: [
            { bits: "15:0"
            }
          ],
        },
        { name: "CTRL",
          desc: "Controls reset, load, and enable signal of the counter.",
          swaccess: "wo",
          hwaccess: "hro",
          hwext: "true",
          fields: [
            { bits: "0", name: "RESET",
              desc: "Reset the counter on rising edge."
            }
            { bits: "1", name: "LOAD",
              desc: "Load the data to the counter on rising edge."
            }
            { bits: "2", name: "EN"
              desc: "Enable the counter on rising edge."
            }
          ]
        },
    ],
}